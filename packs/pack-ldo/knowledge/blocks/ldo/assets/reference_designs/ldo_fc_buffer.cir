* ==================================================================
* LDO Topology C: Folded-Cascode EA → PMOS Pass + Ahuja Compensation
* ==================================================================
* (filename keeps "fc_buffer" tag; will be renamed to ldo_fc_direct.cir)
*
* Topology summary (revised v3 per user feedback):
*   Stage 1 (EA core): Folded-cascode OTA — high gain (~80dB) single
*                      stage. NMOS diff pair → folded into cascode mirror.
*                      Output vea = high-Z cascoded node (very high Rout).
*   No buffer:        FC EA output vea drives PMOS pass gate DIRECTLY.
*                      FC has wide output range, enough to swing PMOS
*                      pass gate from cutoff to strong-on.
*                      No need for separate buffer: FC's high gain
*                      eliminates stage-2 amplifier requirement.
*   Pass:    PMOS pass FET, gate = vea (direct from FC output)
*   Comp:    Ahuja-style cascode compensation — DUAL Cc:
*              Cc1 from vout to vcas_n (NMOS cascode source tap)
*              Cc2 from vout to vcas_p (PMOS cascode source tap)
*            NOT Miller (vea ↔ vout). Avoids RHP zero from feedforward
*            (gm_pass × Cc / I_stage2 driver). Dual-tap covers both
*            signal paths through the folded-cascode mirror.
*   Feedback: R1+R2 divider INSIDE subckt — provides Ibleed = Vout/(R1+R2)
*
* WHY Ahuja vs Miller:
*   Miller compensation creates a RHP zero at fz = gm/Cc which can hurt
*   PM, especially for LDOs with high gm_pass (large pass FET). Ahuja
*   moves the compensation cap from output to a low-impedance cascode
*   "current-sense" node (vcas_n = source of NMOS cascode top device).
*   The cap senses output current change but doesn't feed forward through
*   gm_pass → no RHP zero. Trade-off: requires available cascode tap node
*   (folded-cascode topology naturally has vcas_n), and slightly less
*   compensation efficiency than Miller for the same Cc.
*
* MIRROR PRINCIPLE:
*   All NMOS sinks mirroring Mbias use W=W_bias, L=L_bias — only `m` varies.
*
* DIVIDER PRINCIPLE (LDO IRON LAW):
*   R1+R2 inside subckt; Ibleed = Vout/(R1+R2). Design flow:
*     Step 1: choose Ibleed (power budget + light-load gm_pass need)
*     Step 2: R_total = Vout/Ibleed
*     Step 3: R1:R2 from Vfb/Vout = Vref/Vout
*   No M_bleed needed when divider exists.
*
* EA polarity (FC OTA + direct pass):
*   For NMOS-input FC OTA, the "left" input MN1 is NON-inverting from
*   the perspective of vea (output). For LDO loop:
*     vfb → MN1 (non-inv input)
*     vfb ↑ → vea ↑ (FC EA non-inv)
*     vea ↑ → MP_pass.|Vsg| ↓ → vout ↓ (PMOS pass inv)
*     ∴ vfb ↑ → vout ↓  ✓ NEGATIVE FEEDBACK
*
* Connection rules:
*   - vfb → MN1 (non-inverting input) — vfb is INTERNAL from R1+R2
*   - vref → MN2 (inverting input)
*   - All NMOS sinks mirroring Mbias: W=W_bias, L=L_bias, m varies
*   - Cc between vout ↔ vcas_n (Ahuja, NOT Miller)
*   - R1 between vout-vfb, R2 between vfb-vss
*
* ==================================================================
* Sizing (vpdk180nm, ibias=5µA, Vref=0.9V → Vout=1.2V via divider 1:3)
* ==================================================================
*
*   Bias scaling:
*     I_Mbias    = 5µA
*     I_tail     = 5µA × 4 = 20µA   (m_tail=4)
*     I_fold     = 5µA × 6 = 30µA per branch
*     I_cascode  = I_fold - I_tail/2 = 20µA per branch
*
*   Divider (Ibleed-derived):
*     Target Ibleed = 30µA (low-power, equivalent to "M_bleed m=6")
*     R_total = 1.2V / 30µA = 40kΩ
*     R1 = 10kΩ, R2 = 30kΩ (Vref/Vout = 3/4)
*
*   FC EA devices:
*     MN1/MN2 (diff)   W=14u L=1u (gm/Id ≈ 12, branch I=10µA)
*     MN_tail          W=W_bias L=L_bias m=4 → I=20µA
*     MP_fold_L/R      W=6u  L=1.5u m=6 → I=30µA each
*     MP_pcas_L/R      W=6u  L=1.5u m=4 (cascode top of fold)
*     MN_ncas_L/R      W=4u  L=2u   m=4 (cascode bottom)
*     MN_mir_L/R       W=4u  L=2u   m=4 (bottom mirror)
*
*   Cascode bias (small dedicated devices):
*     MP_vbcp_diode    W=1u   L=0.4u (bias gen for vbc_p)
*     MN_vbcn_diode    W=0.5u L=2u   (bias gen for vbc_n)
*
*   Pass:
*     MP_pass W=1400u L=0.5u m=1
*     gate=vea, vea ∈ [0.5V, 1.4V] → Vsg_pass ∈ [0.4V, 1.3V]
*
*   Compensation (Ahuja dual-tap):
*     Cc1 = 20pF from vout to vcas_n (NMOS cascode source tap)
*     Cc2 = 20pF from vout to vcas_p (PMOS cascode source tap)
*     Dual-tap symmetry compensates BOTH signal paths in the folded
*     cascode (left → vd_left → mirror → vea, and right → vcas_p → vea).
*     Single-cap (only vcas_n) leaves the right-side path under-compensated
*     and PM degrades at heavy load.
* ==================================================================

* NOTE: vfb is exposed as 6th port to allow AC loop-gain testing (Method C)
* via external Rfb/Cfb/Vinj at vfb. In production tests, testbench leaves
* vfb dangling — internal R1+R2 divider drives it.

.subckt ldo_fc_buffer vdd vss vout ibias vref vfb
+ params:
+ W_diff=14u   L_diff=1u
+ W_bias=1u    L_bias=1u
+ W_fold=6u    L_fold=1.5u
+ W_pcas=6u    L_pcas=1.5u  m_pcas=4
+ W_ncas=4u    L_ncas=2u    m_ncas=4
+ W_nmir=4u    L_nmir=2u    m_nmir=4
+ W_pad_p=1u   L_pad_p=0.4u
+ W_pad_n=0.5u L_pad_n=2u
+ W_buf=80u    L_buf=0.5u                 $ PMOS SF input device (2x for heavy load)
+ W_buf_adapt=6u L_buf_adapt=2u            $ NMOS adaptive pull-down at vg_pass (2x)
+ W_adapt_p=1u   L_adapt_p=1u              $ PMOS diode pull-up at vg_pass
+ W_pass=1400u L_pass=0.5u  m_pass=2       $ Pass FET 2x for 30mA OK
+ R_R1=10k     R_R2=30k
+ Cc=200p                                   $ Ahuja larger to push UGF below light-load critical poles
+ I_buf=5u                                  $ ideal current source for buffer (5x for light-load dynamics)
+ m_tail=4 m_fold=6

* === Bias reference: Mbias diode (NMOS) at ibias ===
Mbias  ibias  ibias  vss  vss  nch  W={W_bias} L={L_bias} m=1

* === Cascode bias generators ===
* vbias_fold: NMOS sink (mirror Mbias) + PMOS diode at top
MNfb  vbias_fold ibias       vss        vss  nch W={W_bias}  L={L_bias}  m=1
MPfb  vbias_fold vbias_fold  vdd        vdd  pch W={W_fold}  L={L_fold}  m=1

* vbc_p: low-Vds PMOS cascode bias
MN_vbcp_sink vbc_p      ibias  vss        vss  nch W={W_bias}  L={L_bias}  m=1
MP_vbcp_1    vbc_p_mid  vbc_p  vdd        vdd  pch W={W_pad_p} L={L_pad_p} m=1
MP_vbcp_2    vbc_p      vbc_p  vbc_p_mid  vdd  pch W={W_pcas}  L={L_pcas}  m=1

* vbc_n: low-Vds NMOS cascode bias
MP_vbcn_src  vbc_n      vbias_fold vdd        vdd  pch W={W_fold}  L={L_fold}  m=1
MN_vbcn_2    vbc_n      vbc_n      vbc_n_mid  vss  nch W={W_ncas}  L={L_ncas}  m=1
MN_vbcn_1    vbc_n_mid  vbc_n      vss        vss  nch W={W_pad_n} L={L_pad_n} m=1

* === Folded-cascode EA core ===
* Diff pair: vfb→MN1 (non-inv input), vref→MN2 (inv input); vfb is internal
MN1    vmid_left  vfb   ntail  vss  nch W={W_diff} L={L_diff} m=1
MN2    vcas_p     vref  ntail  vss  nch W={W_diff} L={L_diff} m=1

* MN_tail: NMOS tail mirror Mbias (W=W_bias L=L_bias only m varies)
MN_tail  ntail   ibias  vss    vss  nch W={W_bias} L={L_bias} m={m_tail}

* PMOS fold (top): supplies fold current
MP_fold_L  vmid_left  vbias_fold  vdd  vdd  pch W={W_fold} L={L_fold} m={m_fold}
MP_fold_R  vcas_p     vbias_fold  vdd  vdd  pch W={W_fold} L={L_fold} m={m_fold}

* PMOS cascode (top of mirror)
MP_pcas_L  vd_left  vbc_p  vmid_left  vdd  pch W={W_pcas} L={L_pcas} m={m_pcas}
MP_pcas_R  vea      vbc_p  vcas_p     vdd  pch W={W_pcas} L={L_pcas} m={m_pcas}

* NMOS cascode (bottom of mirror) — vcas_n is the Ahuja comp tap node
MN_ncas_L  vd_left  vbc_n  vmid_left2  vss  nch W={W_ncas} L={L_ncas} m={m_ncas}
MN_ncas_R  vea      vbc_n  vcas_n      vss  nch W={W_ncas} L={L_ncas} m={m_ncas}

* NMOS mirror (bottom): diode at left, mirror at right
MN_mir_L  vmid_left2  vd_left  vss  vss  nch W={W_nmir} L={L_nmir} m={m_nmir}
MN_mir_R  vcas_n      vd_left  vss  vss  nch W={W_nmir} L={L_nmir} m={m_nmir}

* === PMOS Source-Follower Buffer + adaptive pull-down (per wide_range_stable) ===
*  Mbuf: PMOS SF — D=nadapt, G=vea, S=vg_pass, body=vdd
*    vg_pass = vea + Vsg_Mbuf (PMOS SF non-inverting)
*  Ibuf: ideal current source vdd→vg_pass (sets static buffer current)
*  Mbuf_sink: NMOS sink at nadapt, mirror Mbias (W=W_bias L=L_bias)
*  Mbuf_adapt: NMOS adaptive pull-down at vg_pass; gate=nadapt amplifies
*    Mbuf's response — heavy load → vea ↓ → Mbuf I ↑ → nadapt ↑ →
*    Mbuf_adapt sinks more from vg_pass → vg_pass pulled lower (extends
*    drive range beyond plain SF)
*  Madapt_p: PMOS diode at vg_pass — sources current when vg_pass falls,
*    keeps loop alive at very heavy load
* Empirical: this 5-device buffer fixes the FC + direct-drive PM problem
* (PM<20° → expected ~60-80° per analog-design-system wide_range_stable)
Mbuf       nadapt   vea      vg_pass  vdd  pch  W={W_buf}        L={L_buf}        m=1
Ibuf       vdd      vg_pass  DC {I_buf}
Mbuf_sink  nadapt   ibias    vss      vss  nch  W={W_bias}       L={L_bias}       m=1
Mbuf_adapt vg_pass  nadapt   vss      vss  nch  W={W_buf_adapt}  L={L_buf_adapt}  m=1
Madapt_p   vg_pass  vg_pass  vdd      vdd  pch  W={W_adapt_p}    L={L_adapt_p}    m=1

* === PMOS pass FET (gate driven by buffer output vg_pass) ===
MP_pass  vout  vg_pass  vdd  vdd  pch  W={W_pass}  L={L_pass}  m={m_pass}

* === Ahuja-style compensation (vout ↔ vcas_n NMOS cascode tap) ===
*  Now that buffer separates EA output from pass FET gate, Ahuja can
*  work as intended. Cc on low-Z cascode source tap senses output
*  current change without forward-coupling through gm_pass → no RHP zero.
Cc       vout  vcas_n  {Cc}
* === Feedback divider (Ibleed-derived) ===
*  Ibleed = Vout/(R1+R2); Vfb = Vout × R2/(R1+R2) = Vref in regulation
R1  vout  vfb  {R_R1}
R2  vfb   vss  {R_R2}

.ends ldo_fc_buffer

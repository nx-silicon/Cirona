* ==================================================================
* Telescopic OTA (Telescopic Cascode OTA)
* ==================================================================
* Reference Design - NMOS input, single-ended output
* Total: 18 MOSFETs, 0 ideal current sources
* PDK: vpdk180nm (nch / pch)
* ==================================================================
*
* Signal Flow:
*
*   DC current paths (ALL paths from VDD to VSS):
*     Main signal path (left branch):
*       VDD -> MM3(S->D) -> nload_n -> MMcasp3(S->D) -> vout_n
*           -> MMcasc1(D->S) -> ncasc_n -> MM1(D->S) -> ntail
*           -> MMtail(D->S) -> VSS
*     Main signal path (right branch):
*       VDD -> MM4(S->D) -> nload -> MMcasp4(S->D) -> vout
*           -> MMcasc2(D->S) -> ncasc -> MM2(D->S) -> ntail
*           -> MMtail(D->S) -> VSS
*     Bias reference:
*       ibias -> MMbias(diode, D=G=ibias) -> VSS
*       MMtail mirrors ibias: G=ibias, Itail = ibias x (m_tail/m_bias)
*     N-to-P conversion branch:
*       VDD -> MMbp_ref(diode, S->D) -> nbias_p -> MMbn2p(D->S) -> VSS
*     vbnc bias generation branch:
*       VDD -> MMbp_nc(S->D) -> vbnc -> MMbnc_top(diode, D->S)
*           -> vbnc_mid -> MMbnc_bot(linear, D->S) -> VSS
*     vbpc bias generation branch:
*       VDD -> MMbpc_top(linear, S->D) -> vbpc_mid -> MMbpc_bot(diode, S->D)
*           -> vbpc -> MMbn_pc(D->S) -> VSS
*
*   Differential signal (vinp > vinn):
*     1. MM1 current increases dI, MM2 current decreases dI
*     2. MMcasc1/MMcasc2 pass differential current to output nodes
*        (common-gate isolation, boosts output impedance)
*     3. MM3(diode) current follows increase -> nload_n voltage drops
*     4. MM4(mirror) gate follows MM3 -> MM4 current increases dI
*     5. vout: MMcasp4 current increases(up) + MMcasc2 current decreases(down)
*        -> net current 2dI upward
*     6. vout voltage rises: dVout = 2dI x Rout
*
*   Gain: Av = gm1 x Rout
*         Rout = (ro_diff_casc || ro_load_casc)
*         ro_diff_casc = gm_casc x ro_M1 x ro_Mcasc
*         ro_load_casc = gm_casp x ro_M3 x ro_Mcasp
*         Typical gain: 60-80 dB
*
*   GBW:  gm1 / (2*pi * CL)
*
* ASCII Schematic (core OTA):
*
*                         VDD
*                          |
*                +---------+---------+
*                |                   |
*               MM3                 MM4
*            (PMOS)              (PMOS)
*          G=nload_n             G=nload_n
*          D=nload_n             D=nload
*          S=VDD                 S=VDD
*                |                   |
*             MMcasp3             MMcasp4
*            (PMOS)              (PMOS)
*          G=vbpc               G=vbpc
*          D=vout_n             D=vout (output)
*          S=nload_n            S=nload
*                |                   |
*            MMcasc1             MMcasc2
*            (NMOS)              (NMOS)
*          G=vbnc               G=vbnc
*          D=vout_n             D=vout
*          S=ncasc_n            S=ncasc
*                |                   |
*    vinp ---- MM1                  MM2 ---- vinn
*            (NMOS)              (NMOS)
*          D=ncasc_n             D=ncasc
*          G=vinp               G=vinn
*          S=ntail              S=ntail
*                |                   |
*                +--------+----------+
*                         |
*                      MMtail
*                     (NMOS)
*                   D=ntail
*                   G=ibias
*                   S=VSS
*                         |
*                        VSS
*
* Ports:
*   vinp       [INPUT ] - Differential positive input
*   vinn       [INPUT ] - Differential negative input
*   vout       [OUTPUT] - Single-ended output
*   ibias      [INPUT ] - Bias current input (external reference)
*   vdd        [SUPPLY] - Positive supply
*   vss        [GROUND] - Ground
*
* Internal bias nodes (generated by bias tree, 0 ideal sources):
*   ibias   = NMOS diode (MMbias) -> MMtail gate, mirrors to bias branches
*   nbias_p = N-to-P conversion -> PMOS bias reference
*   vbnc    = Vgs_casc + Vds_pad_n ~ 1.0V -> MMcasc1/MMcasc2 gate
*   vbpc    = VDD - |Vds_pad_p| - |Vgs_casp| ~ 0.8V -> MMcasp3/MMcasp4 gate
* ==================================================================

* Parameters (headroom-driven: W_casc=W_diff, W_casp=W_load, use m to adjust)
* Sizing target (VDD=1.8V TT, I_tail=80uA -> I_branch=40uA):
*   Vdsat_tail=0.15, Vdsat_diff=0.14, Vdsat_ncasc=0.14, Vdsat_pcasc=0.14, Vdsat_mirror=0.15
*   Bias-tree branches run at SAME current density as main stack (40uA) so that
*   MMbnc_top / MMbpc_bot produce Vgs matching MMcasc / MMcasp (wide-swing pad).
.param W_diff  = 10u     $ differential pair (MM1, MM2)
.param L_diff  = 1.0u    $ long L for high ro -> gain boost
.param m_diff  = 8       $ Vdsat ~0.19V, lower gm1/C for PM headroom (>60 deg)
.param W_load  = 20u     $ load mirror (MM3, MM4) -- wider W for reasonable |Vgs|
.param L_load  = 1.0u    $ long L (5x Lmin) for matching and high ro
.param m_load  = 8       $ W_eff larger -> Vdsat smaller so |Vds| margin > 0.02V
.param W_casc  = 10u     $ NMOS cascode = W_diff (layout-friendly)
.param L_casc  = 0.5u    $ ~2.8x Lmin: higher cascode ro for gain
.param m_casc  = 4       $ matches diff pair density -> small Vdsat
.param W_casp  = 20u     $ PMOS cascode = W_load (layout-friendly)
.param L_casp  = 0.5u    $ ~2.8x Lmin: higher cascode ro for gain
.param m_casp  = 4       $ matches load density -> small Vdsat
.param m_tail  = 8       $ Itail = ibias x (m_tail/m_bias) = 10u x 8 = 80uA
.param W_bias  = 5u      $ bias reference + tail (shared W/L for mirror accuracy)
.param L_bias  = 1u
.param m_bias  = 1
.param W_pad_n = 1.5u    $ NMOS padding device (vbnc linear region)
.param L_pad_n = 1.5u    $ W/L ~ 1 forces Vds_pad ~ 0.55V so ncasc ~ 0.55V
.param m_pad_n = 1       $ wide-swing pad: pushes ncasc above ntail by >= Vdsat_diff
.param W_pad_p = 10u     $ PMOS padding device (vbpc linear region)
.param L_pad_p = 0.72u   $ sized for |Vds| ~ |Vds_load|
.param m_pad_p = 2       $ W_pad_eff = 20u vs W_casp_eff=80u -> W_main/4 ratio

.subckt telescopic_ota vinp vinn vout ibias vdd vss

    * === bias_mirror (NMOS bias reference + tail current) ===
    * ibias -> MMbias(diode) -> VSS;  MMtail mirrors ibias
    * Itail = ibias x (m_tail / m_bias)
    * NOTE: MMbias and MMtail share W/L for accurate mirroring, only m differs
    MMbias    ibias    ibias   vss vss nch W=W_bias L=L_bias m=m_bias  $ NMOS diode (reference)
    MMtail    ntail    ibias   vss vss nch W=W_bias L=L_bias m=m_tail  $ NMOS mirror -> tail current

    * === n2p_conversion (N-to-P current mirror) ===
    * NMOS mirror copies ibias, PMOS diode establishes PMOS bias reference
    * Path: VDD -> MMbp_ref(S->D) -> nbias_p -> MMbn2p(D->S) -> VSS
    MMbn2p    nbias_p  ibias    vss vss nch W=W_bias L=L_bias m=m_bias  $ NMOS mirror
    MMbp_ref  nbias_p  nbias_p  vdd vdd pch W=W_load L=L_load m=m_load $ PMOS diode

    * === vbnc_generator (NMOS cascode gate bias, wide-swing) ===
    * PMOS mirror provides current; cascode diode + linear padding device
    * Path: VDD -> MMbp_nc(S->D) -> vbnc -> MMbnc_top(diode, D->S) -> vbnc_mid -> MMbnc_bot(linear, D->S) -> VSS
    * MMbnc_top: diode-connected (G=D=vbnc), matches cascode device
    * MMbnc_bot: linear region (G=vbnc, NOT diode), acts as padding resistor
    *   Vds_bot ~ Vds_tail + Vds_diff (keeps diff pair + tail in saturation)
    *   W/L chosen to produce target Vds (e.g., 450mV at 10uA ~ 45kOhm)
    * vbnc = Vgs_casc(diode) + Vds_pad_n(linear)
    * MMbp_nc m bumped to 4*m_load so vbnc branch carries I_branch (40uA), matching MMcasc1/2.
    * This is the key for wide-swing pad: same current density on pad and main cascode.
    MMbp_nc   vbnc     nbias_p  vdd vdd pch W=W_load L=L_load m={m_load*m_tail/(2*m_bias)} $ PMOS mirror: I_bnc = ibias*m_tail/(2*m_bias) = I_branch
    MMbnc_top vbnc     vbnc     vbnc_mid vss nch W=W_casc L=L_casc m=m_casc $ diode (matches cascode)
    MMbnc_bot vbnc_mid vbnc     vss      vss nch W=W_pad_n L=L_pad_n m=m_pad_n $ linear padding

    * === vbpc_generator (PMOS cascode gate bias, wide-swing) ===
    * Cascode diode + linear padding device, NMOS mirror sinks current
    * Path: VDD -> MMbpc_top(linear, S->D) -> vbpc_mid -> MMbpc_bot(diode, S->D) -> vbpc -> MMbn_pc(D->S) -> VSS
    * MMbpc_bot: diode-connected (G=D=vbpc), matches cascode device
    * MMbpc_top: linear region (G=vbpc, NOT diode), acts as padding resistor
    *   |Vds_top| ~ |Vds_load| (keeps load mirror in saturation)
    *   W/L chosen to produce target |Vds| (e.g., 250mV at 10uA)
    * vbpc = VDD - |Vds_pad_p(linear)| - |Vgs_casp(diode)|
    * MMbn_pc m bumped so vbpc branch carries I_branch (40uA), matching MM3/4 + MMcasp3/4.
    * Same-density requirement for wide-swing pad.
    MMbn_pc   vbpc     ibias    vss vss nch W=W_bias L=L_bias m={m_tail/2}  $ NMOS mirror: sinks I_branch = ibias*m_tail/(2*m_bias)
    MMbpc_top vbpc_mid vbpc     vdd vdd pch W=W_pad_p L=L_pad_p m=m_pad_p $ linear padding
    MMbpc_bot vbpc     vbpc     vbpc_mid vdd pch W=W_casp L=L_casp m=m_casp $ diode (matches cascode)

    * === load_mirror (PMOS active load) ===
    * MM3: diode-connected (master), MM4: mirror (slave)
    * Implements diff-to-single-ended conversion
    MM3       nload_n  vout_n   vdd vdd pch W=W_load L=L_load m=m_load  $ diode (master, gate=vout_n via cascode)
    MM4       nload    vout_n   vdd vdd pch W=W_load L=L_load m=m_load  $ mirror (slave, gate=vout_n)

    * === load_cascode (PMOS cascode) ===
    * MMcasp3/MMcasp4 between load mirror and output, boost output impedance
    MMcasp3   vout_n   vbpc     nload_n vdd pch W=W_casp L=L_casp m=m_casp
    MMcasp4   vout     vbpc     nload   vdd pch W=W_casp L=L_casp m=m_casp

    * === input_cascode (NMOS cascode) ===
    * MMcasc1/MMcasc2 between diff pair and output, boost output impedance
    MMcasc1   vout_n   vbnc     ncasc_n vss nch W=W_casc L=L_casc m=m_casc
    MMcasc2   vout     vbnc     ncasc   vss nch W=W_casc L=L_casc m=m_casc

    * === differential_pair ===
    * vinp/vinn -> gm -> current to cascode
    * Each branch current = Itail / 2
    MM1       ncasc_n  vinp     ntail   vss nch W=W_diff L=L_diff m=m_diff
    MM2       ncasc    vinn     ntail   vss nch W=W_diff L=L_diff m=m_diff

.ends telescopic_ota
